# Ansys Electronics Desktop project, version 2022.2
materials:
  vacuum: permittivity=1
  copper: permeability=0.999991 conductivity=58000000
  N87_Core: permittivity=12 permeability=1670 conductivity=0.01

design ETD34 (Maxwell 3D, EddyCurrent, model units mm)
geometry:
  C61036A0103C0180106 [N87_Core] = imported_body(C:\Users\Timothy\Documents\GitHub\ee311-2022-project-project-group-1\Files_Provided\GateReview2\c61036-a0103-c001_ETD34.stp)
  C61036A0103C0180106_1 [N87_Core] = C61036A0103C0180106.duplicate_mirror(point=(0mm, 17.5mm, 0mm), normal=(0mm, 1mm, 0mm))
  C61036A0103C0180106_1.move(0mm, 0.1mm, 0mm)
  Cylinder1 = cylinder(axis=Y, base_centre=(0mm, 7.2mm, 0mm), radius=5.55mm, height=20.6mm)
  Cylinder2 = cylinder(axis=Y, base_centre=(0mm, 7.2mm, 0mm), radius=5.95mm, height=20.6mm)
  Cylinder3 [copper] = cylinder(axis=Y, base_centre=(0mm, 7.2mm, 0mm), radius=6.35mm, height=20.6mm)
  Cylinder3.subtract(Cylinder2)
  Cylinder4 [copper] = cylinder(axis=Y, base_centre=(0mm, 7.2mm, 0mm), radius=5.95mm, height=20.6mm)
  Cylinder4.subtract(Cylinder1)
  Region [vacuum] = region(absolute_offset=500mm on all sides)
  Cylinder4_Section1 [copper] = Cylinder4.section(plane=XY)
  Cylinder3_Section1 = Cylinder3.section(plane=XY)
  Cylinder3_Section1.separate_bodies()
  Cylinder4_Section1.separate_bodies()
  Rectangle1 [non-model] = rectangle(corner=(-50mm, -32.45mm, 0mm), x_size=100mm, y_size=100mm)
  Ellipse1 [non-model] = ellipse(normal=Y, centre=(0mm, 10.55mm, 0mm), major_radius=5.55mm, ratio=1)
  group c61036a0103c001_ETD34 = C61036A0103C0180106, C61036A0103C0180106_1
boundaries and excitations:
  Insulating1: Insulating Objects=Cylinder4
  CoilTerminal1: Coil Terminal Objects=Cylinder3_Section1 Conductor_number=7 Winding=Current_1 Point_out_of_terminal=false
  CoilTerminal2: Coil Terminal Objects=Cylinder4_Section1 Conductor_number=7 Winding=Current_2 Point_out_of_terminal=false
  Current_1: Winding Group Type=Current IsSolid=false Current=2.53A ParallelBranchesNum=1 Phase=0deg
  Current_2: Winding Group Type=Current IsSolid=false Current=0A ParallelBranchesNum=1 Phase=0deg
parameters:
  Matrix1: Matrix Current_1, Current_2:
mesh:
  initial mesh: GlobalCurvilinear{Apply}
setups:
  Setup1: EddyCurrent MaximumPasses=4 MinimumPasses=2 MinimumConvergedPasses=1 PercentRefinement=30 PercentError=1 NonLinearResidual=0.0001 Frequency=100kHz
field plots:
  Mag_B1: B over a plane on Setup1 : LastAdaptive at Freq=100kHz Phase=0deg
reports:
  L Table 1: Matrix1.L(Current_1,Current_1), Matrix1.L(Current_1,Current_2), Matrix1.L(Current_2,Current_2), Matrix1.CplCoef(Current_1,Current_2) vs Freq on Setup1 : LastAdaptive
